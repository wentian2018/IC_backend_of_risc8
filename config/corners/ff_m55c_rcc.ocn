modelFile(
    '("_PDKDIR_/models/spectre/c025bcdgen2_v0d5_usage.scs" "ff_lib")
    '("_EGLDIR_/models/spectre/tsmc025egl.scs"             "ff_5_egl")
    '("_EGLDIR_/models/spectre/tsmc025egl_ldmos.scs"       "ff_hv_egl")
    '("_EGLDIR_/models/spectre/tsmc025egl_res_iso.scs"     "ff_disres_iso")
    '("_THISDIR_/fixed/pex/rcc.scs")
)
option(	'temp  "-55.0" )
temp( -55.0 )

desVar(	  "vdd" 5.5	)
