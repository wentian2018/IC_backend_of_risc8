modelFile(
    '("_PDKDIR_/models/spectre/c025bcdgen2_v0d5_usage.scs" "tt_lib")
    '("_EGLDIR_/models/spectre/tsmc025egl.scs"             "tt_5_egl")
    '("_EGLDIR_/models/spectre/tsmc025egl_ldmos.scs"       "tt_hv_egl")
    '("_EGLDIR_/models/spectre/tsmc025egl_res_iso.scs"     "tt_disres_iso")
    '("_THISDIR_/fixed/pex/rcc.scs")
)
option(	'temp  "25.0" )
temp( 25.0 )

desVar(	  "vdd" 5	)
