modelFile(
    '("_PDKDIR_/models/hspice/c025bcdgen2_v0d5_usage.l"   "tt_lib")
    '("_EGLDIR_/models/hspice/tsmc025egl.l"               "TT_5_EGL")
    '("_EGLDIR_/models/hspice/tsmc025egl_ldmos.l"         "tt_hv_egl")
    '("_EGLDIR_/models/hspice/tsmc025egl_res_iso.l"       "TT_DISRES_ISO")
)
temp( 25.0 )

desVar(	  "vdd" 5	)
